.title KiCad schematic
.include "/home/liam/big_muff_pi_copy/SPICE_MODELS.lib"
R15 /effects_envelope/SIGNAL_IN /effects_sustain/SIGNAL_OUT 0R
C1 Net-_C1-Pad1_ Net-_C1-Pad2_ 1uF
R1 /effects_sustain/SIGNAL_IN Net-_C1-Pad2_ 39kR
V1 /effects_sustain/SIGNAL_IN 0 sin(0 0.5 440)
R2 Net-_C1-Pad1_ 0 100kR
C2 Net-_C1-Pad1_ Net-_C2-Pad2_ 500pF
R4 /effects_sustain/+9V Net-_C2-Pad2_ 15kR
V2 /effects_sustain/+9V 0 dc 9
Q1 Net-_C2-Pad2_ Net-_C1-Pad1_ Net-_Q1-Pad3_ BC547B
R3 Net-_C1-Pad1_ Net-_C2-Pad2_ 470kR
C3 Net-_C2-Pad2_ Net-_C3-Pad2_ 0.1uF
C4 Net-_C4-Pad1_ Net-_C4-Pad2_ 0.1uF
R7 Net-_C3-Pad2_ Net-_C4-Pad2_ 100k
R5 Net-_Q1-Pad3_ 0 100R
R9 Net-_C4-Pad1_ /effects_sustain/SIGNAL_OUT 8.2kR
R8 Net-_C4-Pad2_ Net-_R6-Pad1_ 0
R6 Net-_R6-Pad1_ 0 10kR
V3 unconnected-_V3-Pad1_ 0 sin(0 0.5 440)
D2 Net-_C5-Pad1_ /effects_envelope/SIGNAL_IN 1N914
D1 /effects_envelope/SIGNAL_IN Net-_C5-Pad1_ 1N914
C5 Net-_C5-Pad1_ Net-_C5-Pad2_ 1uF
R11 /effects_envelope/SIGNAL_IN Net-_C5-Pad2_ 470kR
R10 /effects_envelope/SIGNAL_IN 0 100kR
R13 Net-_Q2-Pad3_ 0 100R
Q2 Net-_C5-Pad2_ /effects_envelope/SIGNAL_IN Net-_Q2-Pad3_ BC547B
C6 /effects_envelope/SIGNAL_IN Net-_C5-Pad2_ 500pF
R14 Net-_C7-Pad2_ /effects_envelope/SIGNAL_OUT 8.2kR
C7 Net-_C5-Pad2_ Net-_C7-Pad2_ 0.1uF
R12 /effects_envelope/+9V Net-_C5-Pad2_ 15kR
.end
